* ============================================================
* 共射放大电路 SPICE 仿真示例
* ============================================================
* 用法（任选其一）：
*   ngspice  :  ngspice -b ce_amp.cir
*   LTspice  :  File -> Open -> 选择本文件 -> Run
*
* 本网表与 bjt_bias.py 中的电路参数完全一致，
* 可以把 Python 手算结果与 SPICE 仿真结果对照，验证模型的准确性。
* 手算参考值：ICQ ~ 1.56 mA, VCEQ ~ 5.28 V, Av ~ -150
* ============================================================

.title Common-Emitter Amplifier

* ---------- 电源 ----------
VCC   vcc   0     DC 12
* 交流小信号源：1 mV 幅度，用于交流扫描；瞬态用 1 kHz 正弦
VIN   in    0     DC 0 AC 1 SIN(0 1m 1k)

* ---------- 偏置网络 ----------
R1    vcc   base  40k
R2    base  0     10k
RC    vcc   coll  3.3k
RE    emit  0     1k

* ---------- 耦合与旁路电容 ----------
C1    in    base  10u        ; 输入耦合，决定下限频率
C2    coll  out   10u        ; 输出耦合
CE    emit  0     100u       ; 射极旁路，交流短路 RE 以获得高增益

* ---------- 负载 ----------
RL    out   0     10k

* ---------- 晶体管 ----------
Q1    coll  base  emit  QMOD

* 通用 NPN 模型（近似 2N2222）
.model QMOD NPN (IS=1e-14 BF=100 VAF=100 RB=10 RC=1 RE=0.5
+                CJE=25p CJC=8p TF=0.4n TR=100n)

* ============================================================
* 分析指令
* ============================================================

* 1) 静态工作点：输出各节点直流电位与器件电流
.op

* 2) 交流小信号扫描：10 Hz ~ 100 MHz，每十倍频 20 点
*    观察中频增益、下限频率 fL、上限频率 fH
.ac dec 20 10 100meg

* 3) 瞬态分析：看 1 kHz 正弦的放大波形与相位反转
.tran 10u 5m

* ============================================================
* ngspice 批处理输出控制
* ============================================================
.control
  run
  echo "===== 静态工作点 ====="
  print v(base) v(emit) v(coll)
  print i(vcc)
  echo "===== 中频增益 (1 kHz) ====="
  * 增益 = vout/vin，取 dB
  let gain_db = db(v(out))
  meas ac midgain  MAX vdb(out)
  meas ac fl  WHEN vdb(out)=midgain-3 RISE=1
  meas ac fh  WHEN vdb(out)=midgain-3 FALL=1
  echo "中频增益 / 下限频率 fL / 上限频率 fH 见上方 meas 输出"
.endc

.end
